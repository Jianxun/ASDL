// Netlist generated by ASDL for backend `sim.spectre`
simulator lang=spectre
global 0

// ===============================================
// current_mirror_array_nmos
// /Users/jianxunzhu/Documents/GitHub/osic-suite/ASDL/examples/scratch/mosbius_devices/current_mirror_array_nmos.asdl
// ===============================================
subckt current_mirror_array_nmos (iref iout_1x iout_2x iout_4x iout_8x iout_16x VSS)
mn_ref (iref iref VSS VSS) nmos_3p3 L=0.5u W=5u NF=6 m=1
mn_out1 (iout_1x iref VSS VSS) nmos_3p3 L=0.5u W=5u NF=6 m=1
mn_out2 (iout_2x iref VSS VSS) nmos_3p3 L=0.5u W=5u NF=6 m=2
mn_out4 (iout_4x iref VSS VSS) nmos_3p3 L=0.5u W=5u NF=6 m=4
mn_out8 (iout_8x iref VSS VSS) nmos_3p3 L=0.5u W=5u NF=6 m=8
mn_out16 (iout_16x iref VSS VSS) nmos_3p3 L=0.5u W=5u NF=6 m=16
ends
