// Netlist generated by ASDL for backend `sim.spectre`
simulator lang=spectre
global 0

// ===============================================
// ota_nmos2
// /Users/jianxunzhu/Documents/GitHub/osic-suite/ASDL/examples/scratch/mosbius_devices/ota_nmos2.asdl
// ===============================================
subckt ota_nmos2 (IN_P IN_N OUT VBN VSS VDD)
MP_LOAD_P (D D VDD VDD) pmos_3p3 L=0.28u W=1u NF=1 m=3
MP_LOAD_N (OUT D VDD VDD) pmos_3p3 L=0.28u W=1u NF=1 m=3
MN_IN_P (D IN_P TAIL VDD) nmos_3p3 L=0.28u W=1u NF=1 m=1
MN_IN_N (OUT IN_N TAIL VDD) nmos_3p3 L=0.28u W=1u NF=1 m=1
MN_TAIL (TAIL VBN VSS VSS) nmos_3p3 L=0.28u W=1u NF=1 m=2
ends
