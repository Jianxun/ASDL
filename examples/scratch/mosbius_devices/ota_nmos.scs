// Netlist generated by ASDL for backend `sim.spectre`
simulator lang=spectre
global 0

// ===============================================
// ota_nmos
// /Users/jianxunzhu/Documents/GitHub/osic-suite/ASDL/examples/scratch/mosbius_devices/ota_nmos.asdl
// ===============================================
subckt ota_nmos (IN_P IN_N OUT VBN VSS VDD)
MP_DIO (D D VDD VDD) pmos_3p3 L=0.28u W=1u NF=1 m=3
MP_OUT (OUT D VDD VDD) pmos_3p3 L=0.28u W=1u NF=1 m=3
MN_IN_P (D IN_P TAIL VSS) nmos_3p3 L=0.28u W=1u NF=1 m=1
MN_IN_N (OUT IN_N TAIL VSS) nmos_3p3 L=0.28u W=1u NF=1 m=1
MN_TAIL (TAIL VBN VSS VSS) nmos_3p3 L=0.28u W=1u NF=1 m=2
ends
