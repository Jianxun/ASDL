// Netlist generated by ASDL for backend `sim.spectre`
simulator lang=spectre
global 0

// ===============================================
// tb
// /Users/jianxunzhu/Documents/GitHub/asdl_ecosystem/ASDL/examples/libs/scratch/cc_nmos.asdl
// ===============================================
subckt tb ()
dut (0 G D) cc_nmos parameters m=2
ends

// ===============================================
// cc_nmos
// /Users/jianxunzhu/Documents/GitHub/asdl_ecosystem/ASDL/examples/libs/scratch/cc_nmos.asdl
// ===============================================
subckt cc_nmos (VSS G D) parameters m=1
mn_cs (D G VSS VSS) nmos_3p3 L=0.28u W=8u NF=6 m=m
ends
